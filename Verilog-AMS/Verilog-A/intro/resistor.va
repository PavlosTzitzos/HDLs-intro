/* resistor

1          2 : ports p1(+) and p2(-)
o--\/\/\/--o
    I-->     : current flow

Equation : V = R*I

*/

`include "constants.vams"
`include "disciplines.vams"

module resistor(p1,p2);

inout p1,p2;

electrical p1,p2;

`define attr(txt) (*txt*)
parameter real R = 1000.0 from (0.0:inf] `attr(info="Resistance" unit="Ohms");

analog begin
	V(p1,p2) <+ R*I(p1,p2);
end

endmodule
