module diode (a , c);
inout a , c;
electrical a , c;
real Id , Is;
real Rp;

analog begin
    Rp = 1-e9;
    Is = 1e-15;
    Id = I s * (exp(V(a , c) / 26e-3) -1);
    I(a , c) <+ Id;
    // allowedd in ADMS
    I(a , c) <+ V(a , c) / Rp;
    // not allowed in ADMS
    V(a , c) <+ I(a , c) * Rp;
end
endmodule
