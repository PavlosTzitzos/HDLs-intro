module resistor (t1, t2);

//electrical ports:
electrical t1, t2;

//parameter of the module:
parameter real r=1;

//output:
branch (t1, t2) res;

//analog block:
analog V(res) <+ r*I(res);
// inside the analog block declare the equation : V = r*I

endmodule
